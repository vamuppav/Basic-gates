ADE simulation setup
Run mode: Single Run, Sweeps and Corners
Tests:
  inverter_pro637:test_bench:1: inverter_pro637/test_bench/schematic, simulator spectre
