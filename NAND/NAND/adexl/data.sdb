ADE simulation setup
Run mode: Single Run, Sweeps and Corners
Tests:
  NAND_pro637:test_bench:1: NAND_pro637/test_bench/schematic, simulator spectre
