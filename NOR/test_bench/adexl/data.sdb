ADE simulation setup
Run mode: Single Run, Sweeps and Corners
Tests:
  NOR_pro637:test_bench:1: NOR_pro637/test_bench/config, simulator spectre
